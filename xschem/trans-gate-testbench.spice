**.subckt trans-gate-testbench
V1 net1 GND SIN(0 0.5 40)
V2 net2 GND 1.8
V3 net3 GND 0
**** begin user architecture code
 ** manual skywater pdks install (with patches applied)
* .lib /ef/tech/SW.2/sky130A/libs.tech/ngspice/models/sky130.lib.spice tt

** opencircuitdesign pdks install
.lib /ef/tech/SW.2/sky130A/libs.tech/ngspice/sky130.lib.spice tt

.param mc_mm_switch=0
.param mc_pr_switch=0

.tran 0.001s 0.1s
.control
  run
  plot v(output) v(net1)
.endc
.save all

**** end user architecture code
**.ends
.GLOBAL GND
** flattened .save nodes
.end
